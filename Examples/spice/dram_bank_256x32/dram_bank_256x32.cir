transistor-level 256x32 DRAM bank core
* AUTOGENERATED by generate.py. Supplies and controls are boundary ports.
* The component accepts one-hot wordline and column-select rails; testbench
* drivers are intentionally outside the proved component.
* Coupling and sense are separate phases: restore/restoreb connect the
* bitline pair to the latch, then sensehi/senselo energize the latch.
.subckt dram_sense_amp q qb sensehi senselo
mpq q qb sensehi sensehi psense
mnq q qb senselo senselo nmod
mpqb qb q sensehi sensehi psense
mnqb qb q senselo senselo nmod
cq q 0 300f
cqb qb 0 300f
.ends dram_sense_amp
.subckt tg left right enable enableb vdd
mn left enable right 0 nmod
mp left enableb right vdd pmod
.ends tg
.subckt dram_cell store word bit
maccess store word bit 0 nmod
cstore store 0 30f
.ends dram_cell
.subckt dram_row32 word bit0 bit1 bit2 bit3 bit4 bit5 bit6 bit7 bit8 bit9 bit10 bit11 bit12 bit13 bit14 bit15 bit16 bit17 bit18 bit19 bit20 bit21 bit22 bit23 bit24 bit25 bit26 bit27 bit28 bit29 bit30 bit31
xcell0 store0 word bit0 dram_cell
xcell1 store1 word bit1 dram_cell
xcell2 store2 word bit2 dram_cell
xcell3 store3 word bit3 dram_cell
xcell4 store4 word bit4 dram_cell
xcell5 store5 word bit5 dram_cell
xcell6 store6 word bit6 dram_cell
xcell7 store7 word bit7 dram_cell
xcell8 store8 word bit8 dram_cell
xcell9 store9 word bit9 dram_cell
xcell10 store10 word bit10 dram_cell
xcell11 store11 word bit11 dram_cell
xcell12 store12 word bit12 dram_cell
xcell13 store13 word bit13 dram_cell
xcell14 store14 word bit14 dram_cell
xcell15 store15 word bit15 dram_cell
xcell16 store16 word bit16 dram_cell
xcell17 store17 word bit17 dram_cell
xcell18 store18 word bit18 dram_cell
xcell19 store19 word bit19 dram_cell
xcell20 store20 word bit20 dram_cell
xcell21 store21 word bit21 dram_cell
xcell22 store22 word bit22 dram_cell
xcell23 store23 word bit23 dram_cell
xcell24 store24 word bit24 dram_cell
xcell25 store25 word bit25 dram_cell
xcell26 store26 word bit26 dram_cell
xcell27 store27 word bit27 dram_cell
xcell28 store28 word bit28 dram_cell
xcell29 store29 word bit29 dram_cell
xcell30 store30 word bit30 dram_cell
xcell31 store31 word bit31 dram_cell
.ends dram_row32
.subckt dram_subarray16x32 word0 word1 word2 word3 word4 word5 word6 word7 word8 word9 word10 word11 word12 word13 word14 word15 bit0 bit1 bit2 bit3 bit4 bit5 bit6 bit7 bit8 bit9 bit10 bit11 bit12 bit13 bit14 bit15 bit16 bit17 bit18 bit19 bit20 bit21 bit22 bit23 bit24 bit25 bit26 bit27 bit28 bit29 bit30 bit31
xrow0 word0 bit0 bit1 bit2 bit3 bit4 bit5 bit6 bit7 bit8 bit9 bit10 bit11 bit12 bit13 bit14 bit15 bit16 bit17 bit18 bit19 bit20 bit21 bit22 bit23 bit24 bit25 bit26 bit27 bit28 bit29 bit30 bit31 dram_row32
xrow1 word1 bit0 bit1 bit2 bit3 bit4 bit5 bit6 bit7 bit8 bit9 bit10 bit11 bit12 bit13 bit14 bit15 bit16 bit17 bit18 bit19 bit20 bit21 bit22 bit23 bit24 bit25 bit26 bit27 bit28 bit29 bit30 bit31 dram_row32
xrow2 word2 bit0 bit1 bit2 bit3 bit4 bit5 bit6 bit7 bit8 bit9 bit10 bit11 bit12 bit13 bit14 bit15 bit16 bit17 bit18 bit19 bit20 bit21 bit22 bit23 bit24 bit25 bit26 bit27 bit28 bit29 bit30 bit31 dram_row32
xrow3 word3 bit0 bit1 bit2 bit3 bit4 bit5 bit6 bit7 bit8 bit9 bit10 bit11 bit12 bit13 bit14 bit15 bit16 bit17 bit18 bit19 bit20 bit21 bit22 bit23 bit24 bit25 bit26 bit27 bit28 bit29 bit30 bit31 dram_row32
xrow4 word4 bit0 bit1 bit2 bit3 bit4 bit5 bit6 bit7 bit8 bit9 bit10 bit11 bit12 bit13 bit14 bit15 bit16 bit17 bit18 bit19 bit20 bit21 bit22 bit23 bit24 bit25 bit26 bit27 bit28 bit29 bit30 bit31 dram_row32
xrow5 word5 bit0 bit1 bit2 bit3 bit4 bit5 bit6 bit7 bit8 bit9 bit10 bit11 bit12 bit13 bit14 bit15 bit16 bit17 bit18 bit19 bit20 bit21 bit22 bit23 bit24 bit25 bit26 bit27 bit28 bit29 bit30 bit31 dram_row32
xrow6 word6 bit0 bit1 bit2 bit3 bit4 bit5 bit6 bit7 bit8 bit9 bit10 bit11 bit12 bit13 bit14 bit15 bit16 bit17 bit18 bit19 bit20 bit21 bit22 bit23 bit24 bit25 bit26 bit27 bit28 bit29 bit30 bit31 dram_row32
xrow7 word7 bit0 bit1 bit2 bit3 bit4 bit5 bit6 bit7 bit8 bit9 bit10 bit11 bit12 bit13 bit14 bit15 bit16 bit17 bit18 bit19 bit20 bit21 bit22 bit23 bit24 bit25 bit26 bit27 bit28 bit29 bit30 bit31 dram_row32
xrow8 word8 bit0 bit1 bit2 bit3 bit4 bit5 bit6 bit7 bit8 bit9 bit10 bit11 bit12 bit13 bit14 bit15 bit16 bit17 bit18 bit19 bit20 bit21 bit22 bit23 bit24 bit25 bit26 bit27 bit28 bit29 bit30 bit31 dram_row32
xrow9 word9 bit0 bit1 bit2 bit3 bit4 bit5 bit6 bit7 bit8 bit9 bit10 bit11 bit12 bit13 bit14 bit15 bit16 bit17 bit18 bit19 bit20 bit21 bit22 bit23 bit24 bit25 bit26 bit27 bit28 bit29 bit30 bit31 dram_row32
xrow10 word10 bit0 bit1 bit2 bit3 bit4 bit5 bit6 bit7 bit8 bit9 bit10 bit11 bit12 bit13 bit14 bit15 bit16 bit17 bit18 bit19 bit20 bit21 bit22 bit23 bit24 bit25 bit26 bit27 bit28 bit29 bit30 bit31 dram_row32
xrow11 word11 bit0 bit1 bit2 bit3 bit4 bit5 bit6 bit7 bit8 bit9 bit10 bit11 bit12 bit13 bit14 bit15 bit16 bit17 bit18 bit19 bit20 bit21 bit22 bit23 bit24 bit25 bit26 bit27 bit28 bit29 bit30 bit31 dram_row32
xrow12 word12 bit0 bit1 bit2 bit3 bit4 bit5 bit6 bit7 bit8 bit9 bit10 bit11 bit12 bit13 bit14 bit15 bit16 bit17 bit18 bit19 bit20 bit21 bit22 bit23 bit24 bit25 bit26 bit27 bit28 bit29 bit30 bit31 dram_row32
xrow13 word13 bit0 bit1 bit2 bit3 bit4 bit5 bit6 bit7 bit8 bit9 bit10 bit11 bit12 bit13 bit14 bit15 bit16 bit17 bit18 bit19 bit20 bit21 bit22 bit23 bit24 bit25 bit26 bit27 bit28 bit29 bit30 bit31 dram_row32
xrow14 word14 bit0 bit1 bit2 bit3 bit4 bit5 bit6 bit7 bit8 bit9 bit10 bit11 bit12 bit13 bit14 bit15 bit16 bit17 bit18 bit19 bit20 bit21 bit22 bit23 bit24 bit25 bit26 bit27 bit28 bit29 bit30 bit31 dram_row32
xrow15 word15 bit0 bit1 bit2 bit3 bit4 bit5 bit6 bit7 bit8 bit9 bit10 bit11 bit12 bit13 bit14 bit15 bit16 bit17 bit18 bit19 bit20 bit21 bit22 bit23 bit24 bit25 bit26 bit27 bit28 bit29 bit30 bit31 dram_row32
.ends dram_subarray16x32
.subckt dram_column bit select selectb vdd vpre precharge restore restoreb sensehi senselo dout writebus
cbit bit 0 300f
cref ref 0 300f
mpre bit precharge vpre 0 nmod
mpreref ref precharge vpre 0 nmod
xpreq q vpre restoreb restore vdd tg
xpreqb qb vpre restoreb restore vdd tg
xsense q qb sensehi senselo dram_sense_amp
xcouple bit q restore restoreb vdd tg
xcoupleb ref qb restore restoreb vdd tg
xreadmux q dout select selectb vdd tg
xwritemux writebus bit select selectb vdd tg
.ends dram_column
.subckt dram_bank_256x32 vdd vpre precharge restore restoreb sensehi senselo write writeb din dout word0 word1 word2 word3 word4 word5 word6 word7 word8 word9 word10 word11 word12 word13 word14 word15 word16 word17 word18 word19 word20 word21 word22 word23 word24 word25 word26 word27 word28 word29 word30 word31 word32 word33 word34 word35 word36 word37 word38 word39 word40 word41 word42 word43 word44 word45 word46 word47 word48 word49 word50 word51 word52 word53 word54 word55 word56 word57 word58 word59 word60 word61 word62 word63 word64 word65 word66 word67 word68 word69 word70 word71 word72 word73 word74 word75 word76 word77 word78 word79 word80 word81 word82 word83 word84 word85 word86 word87 word88 word89 word90 word91 word92 word93 word94 word95 word96 word97 word98 word99 word100 word101 word102 word103 word104 word105 word106 word107 word108 word109 word110 word111 word112 word113 word114 word115 word116 word117 word118 word119 word120 word121 word122 word123 word124 word125 word126 word127 word128 word129 word130 word131 word132 word133 word134 word135 word136 word137 word138 word139 word140 word141 word142 word143 word144 word145 word146 word147 word148 word149 word150 word151 word152 word153 word154 word155 word156 word157 word158 word159 word160 word161 word162 word163 word164 word165 word166 word167 word168 word169 word170 word171 word172 word173 word174 word175 word176 word177 word178 word179 word180 word181 word182 word183 word184 word185 word186 word187 word188 word189 word190 word191 word192 word193 word194 word195 word196 word197 word198 word199 word200 word201 word202 word203 word204 word205 word206 word207 word208 word209 word210 word211 word212 word213 word214 word215 word216 word217 word218 word219 word220 word221 word222 word223 word224 word225 word226 word227 word228 word229 word230 word231 word232 word233 word234 word235 word236 word237 word238 word239 word240 word241 word242 word243 word244 word245 word246 word247 word248 word249 word250 word251 word252 word253 word254 word255 select0 selectb0 select1 selectb1 select2 selectb2 select3 selectb3 select4 selectb4 select5 selectb5 select6 selectb6 select7 selectb7 select8 selectb8 select9 selectb9 select10 selectb10 select11 selectb11 select12 selectb12 select13 selectb13 select14 selectb14 select15 selectb15 select16 selectb16 select17 selectb17 select18 selectb18 select19 selectb19 select20 selectb20 select21 selectb21 select22 selectb22 select23 selectb23 select24 selectb24 select25 selectb25 select26 selectb26 select27 selectb27 select28 selectb28 select29 selectb29 select30 selectb30 select31 selectb31
xsub0 word0 word1 word2 word3 word4 word5 word6 word7 word8 word9 word10 word11 word12 word13 word14 word15 bit0 bit1 bit2 bit3 bit4 bit5 bit6 bit7 bit8 bit9 bit10 bit11 bit12 bit13 bit14 bit15 bit16 bit17 bit18 bit19 bit20 bit21 bit22 bit23 bit24 bit25 bit26 bit27 bit28 bit29 bit30 bit31 dram_subarray16x32
xsub1 word16 word17 word18 word19 word20 word21 word22 word23 word24 word25 word26 word27 word28 word29 word30 word31 bit0 bit1 bit2 bit3 bit4 bit5 bit6 bit7 bit8 bit9 bit10 bit11 bit12 bit13 bit14 bit15 bit16 bit17 bit18 bit19 bit20 bit21 bit22 bit23 bit24 bit25 bit26 bit27 bit28 bit29 bit30 bit31 dram_subarray16x32
xsub2 word32 word33 word34 word35 word36 word37 word38 word39 word40 word41 word42 word43 word44 word45 word46 word47 bit0 bit1 bit2 bit3 bit4 bit5 bit6 bit7 bit8 bit9 bit10 bit11 bit12 bit13 bit14 bit15 bit16 bit17 bit18 bit19 bit20 bit21 bit22 bit23 bit24 bit25 bit26 bit27 bit28 bit29 bit30 bit31 dram_subarray16x32
xsub3 word48 word49 word50 word51 word52 word53 word54 word55 word56 word57 word58 word59 word60 word61 word62 word63 bit0 bit1 bit2 bit3 bit4 bit5 bit6 bit7 bit8 bit9 bit10 bit11 bit12 bit13 bit14 bit15 bit16 bit17 bit18 bit19 bit20 bit21 bit22 bit23 bit24 bit25 bit26 bit27 bit28 bit29 bit30 bit31 dram_subarray16x32
xsub4 word64 word65 word66 word67 word68 word69 word70 word71 word72 word73 word74 word75 word76 word77 word78 word79 bit0 bit1 bit2 bit3 bit4 bit5 bit6 bit7 bit8 bit9 bit10 bit11 bit12 bit13 bit14 bit15 bit16 bit17 bit18 bit19 bit20 bit21 bit22 bit23 bit24 bit25 bit26 bit27 bit28 bit29 bit30 bit31 dram_subarray16x32
xsub5 word80 word81 word82 word83 word84 word85 word86 word87 word88 word89 word90 word91 word92 word93 word94 word95 bit0 bit1 bit2 bit3 bit4 bit5 bit6 bit7 bit8 bit9 bit10 bit11 bit12 bit13 bit14 bit15 bit16 bit17 bit18 bit19 bit20 bit21 bit22 bit23 bit24 bit25 bit26 bit27 bit28 bit29 bit30 bit31 dram_subarray16x32
xsub6 word96 word97 word98 word99 word100 word101 word102 word103 word104 word105 word106 word107 word108 word109 word110 word111 bit0 bit1 bit2 bit3 bit4 bit5 bit6 bit7 bit8 bit9 bit10 bit11 bit12 bit13 bit14 bit15 bit16 bit17 bit18 bit19 bit20 bit21 bit22 bit23 bit24 bit25 bit26 bit27 bit28 bit29 bit30 bit31 dram_subarray16x32
xsub7 word112 word113 word114 word115 word116 word117 word118 word119 word120 word121 word122 word123 word124 word125 word126 word127 bit0 bit1 bit2 bit3 bit4 bit5 bit6 bit7 bit8 bit9 bit10 bit11 bit12 bit13 bit14 bit15 bit16 bit17 bit18 bit19 bit20 bit21 bit22 bit23 bit24 bit25 bit26 bit27 bit28 bit29 bit30 bit31 dram_subarray16x32
xsub8 word128 word129 word130 word131 word132 word133 word134 word135 word136 word137 word138 word139 word140 word141 word142 word143 bit0 bit1 bit2 bit3 bit4 bit5 bit6 bit7 bit8 bit9 bit10 bit11 bit12 bit13 bit14 bit15 bit16 bit17 bit18 bit19 bit20 bit21 bit22 bit23 bit24 bit25 bit26 bit27 bit28 bit29 bit30 bit31 dram_subarray16x32
xsub9 word144 word145 word146 word147 word148 word149 word150 word151 word152 word153 word154 word155 word156 word157 word158 word159 bit0 bit1 bit2 bit3 bit4 bit5 bit6 bit7 bit8 bit9 bit10 bit11 bit12 bit13 bit14 bit15 bit16 bit17 bit18 bit19 bit20 bit21 bit22 bit23 bit24 bit25 bit26 bit27 bit28 bit29 bit30 bit31 dram_subarray16x32
xsub10 word160 word161 word162 word163 word164 word165 word166 word167 word168 word169 word170 word171 word172 word173 word174 word175 bit0 bit1 bit2 bit3 bit4 bit5 bit6 bit7 bit8 bit9 bit10 bit11 bit12 bit13 bit14 bit15 bit16 bit17 bit18 bit19 bit20 bit21 bit22 bit23 bit24 bit25 bit26 bit27 bit28 bit29 bit30 bit31 dram_subarray16x32
xsub11 word176 word177 word178 word179 word180 word181 word182 word183 word184 word185 word186 word187 word188 word189 word190 word191 bit0 bit1 bit2 bit3 bit4 bit5 bit6 bit7 bit8 bit9 bit10 bit11 bit12 bit13 bit14 bit15 bit16 bit17 bit18 bit19 bit20 bit21 bit22 bit23 bit24 bit25 bit26 bit27 bit28 bit29 bit30 bit31 dram_subarray16x32
xsub12 word192 word193 word194 word195 word196 word197 word198 word199 word200 word201 word202 word203 word204 word205 word206 word207 bit0 bit1 bit2 bit3 bit4 bit5 bit6 bit7 bit8 bit9 bit10 bit11 bit12 bit13 bit14 bit15 bit16 bit17 bit18 bit19 bit20 bit21 bit22 bit23 bit24 bit25 bit26 bit27 bit28 bit29 bit30 bit31 dram_subarray16x32
xsub13 word208 word209 word210 word211 word212 word213 word214 word215 word216 word217 word218 word219 word220 word221 word222 word223 bit0 bit1 bit2 bit3 bit4 bit5 bit6 bit7 bit8 bit9 bit10 bit11 bit12 bit13 bit14 bit15 bit16 bit17 bit18 bit19 bit20 bit21 bit22 bit23 bit24 bit25 bit26 bit27 bit28 bit29 bit30 bit31 dram_subarray16x32
xsub14 word224 word225 word226 word227 word228 word229 word230 word231 word232 word233 word234 word235 word236 word237 word238 word239 bit0 bit1 bit2 bit3 bit4 bit5 bit6 bit7 bit8 bit9 bit10 bit11 bit12 bit13 bit14 bit15 bit16 bit17 bit18 bit19 bit20 bit21 bit22 bit23 bit24 bit25 bit26 bit27 bit28 bit29 bit30 bit31 dram_subarray16x32
xsub15 word240 word241 word242 word243 word244 word245 word246 word247 word248 word249 word250 word251 word252 word253 word254 word255 bit0 bit1 bit2 bit3 bit4 bit5 bit6 bit7 bit8 bit9 bit10 bit11 bit12 bit13 bit14 bit15 bit16 bit17 bit18 bit19 bit20 bit21 bit22 bit23 bit24 bit25 bit26 bit27 bit28 bit29 bit30 bit31 dram_subarray16x32
xcolumn0 bit0 select0 selectb0 vdd vpre precharge restore restoreb sensehi senselo dout writebus dram_column
xcolumn1 bit1 select1 selectb1 vdd vpre precharge restore restoreb sensehi senselo dout writebus dram_column
xcolumn2 bit2 select2 selectb2 vdd vpre precharge restore restoreb sensehi senselo dout writebus dram_column
xcolumn3 bit3 select3 selectb3 vdd vpre precharge restore restoreb sensehi senselo dout writebus dram_column
xcolumn4 bit4 select4 selectb4 vdd vpre precharge restore restoreb sensehi senselo dout writebus dram_column
xcolumn5 bit5 select5 selectb5 vdd vpre precharge restore restoreb sensehi senselo dout writebus dram_column
xcolumn6 bit6 select6 selectb6 vdd vpre precharge restore restoreb sensehi senselo dout writebus dram_column
xcolumn7 bit7 select7 selectb7 vdd vpre precharge restore restoreb sensehi senselo dout writebus dram_column
xcolumn8 bit8 select8 selectb8 vdd vpre precharge restore restoreb sensehi senselo dout writebus dram_column
xcolumn9 bit9 select9 selectb9 vdd vpre precharge restore restoreb sensehi senselo dout writebus dram_column
xcolumn10 bit10 select10 selectb10 vdd vpre precharge restore restoreb sensehi senselo dout writebus dram_column
xcolumn11 bit11 select11 selectb11 vdd vpre precharge restore restoreb sensehi senselo dout writebus dram_column
xcolumn12 bit12 select12 selectb12 vdd vpre precharge restore restoreb sensehi senselo dout writebus dram_column
xcolumn13 bit13 select13 selectb13 vdd vpre precharge restore restoreb sensehi senselo dout writebus dram_column
xcolumn14 bit14 select14 selectb14 vdd vpre precharge restore restoreb sensehi senselo dout writebus dram_column
xcolumn15 bit15 select15 selectb15 vdd vpre precharge restore restoreb sensehi senselo dout writebus dram_column
xcolumn16 bit16 select16 selectb16 vdd vpre precharge restore restoreb sensehi senselo dout writebus dram_column
xcolumn17 bit17 select17 selectb17 vdd vpre precharge restore restoreb sensehi senselo dout writebus dram_column
xcolumn18 bit18 select18 selectb18 vdd vpre precharge restore restoreb sensehi senselo dout writebus dram_column
xcolumn19 bit19 select19 selectb19 vdd vpre precharge restore restoreb sensehi senselo dout writebus dram_column
xcolumn20 bit20 select20 selectb20 vdd vpre precharge restore restoreb sensehi senselo dout writebus dram_column
xcolumn21 bit21 select21 selectb21 vdd vpre precharge restore restoreb sensehi senselo dout writebus dram_column
xcolumn22 bit22 select22 selectb22 vdd vpre precharge restore restoreb sensehi senselo dout writebus dram_column
xcolumn23 bit23 select23 selectb23 vdd vpre precharge restore restoreb sensehi senselo dout writebus dram_column
xcolumn24 bit24 select24 selectb24 vdd vpre precharge restore restoreb sensehi senselo dout writebus dram_column
xcolumn25 bit25 select25 selectb25 vdd vpre precharge restore restoreb sensehi senselo dout writebus dram_column
xcolumn26 bit26 select26 selectb26 vdd vpre precharge restore restoreb sensehi senselo dout writebus dram_column
xcolumn27 bit27 select27 selectb27 vdd vpre precharge restore restoreb sensehi senselo dout writebus dram_column
xcolumn28 bit28 select28 selectb28 vdd vpre precharge restore restoreb sensehi senselo dout writebus dram_column
xcolumn29 bit29 select29 selectb29 vdd vpre precharge restore restoreb sensehi senselo dout writebus dram_column
xcolumn30 bit30 select30 selectb30 vdd vpre precharge restore restoreb sensehi senselo dout writebus dram_column
xcolumn31 bit31 select31 selectb31 vdd vpre precharge restore restoreb sensehi senselo dout writebus dram_column
xwrite din writebus write writeb vdd tg
.ends dram_bank_256x32
xbank vdd vpre precharge restore restoreb sensehi senselo write writeb din dout word0 word1 word2 word3 word4 word5 word6 word7 word8 word9 word10 word11 word12 word13 word14 word15 word16 word17 word18 word19 word20 word21 word22 word23 word24 word25 word26 word27 word28 word29 word30 word31 word32 word33 word34 word35 word36 word37 word38 word39 word40 word41 word42 word43 word44 word45 word46 word47 word48 word49 word50 word51 word52 word53 word54 word55 word56 word57 word58 word59 word60 word61 word62 word63 word64 word65 word66 word67 word68 word69 word70 word71 word72 word73 word74 word75 word76 word77 word78 word79 word80 word81 word82 word83 word84 word85 word86 word87 word88 word89 word90 word91 word92 word93 word94 word95 word96 word97 word98 word99 word100 word101 word102 word103 word104 word105 word106 word107 word108 word109 word110 word111 word112 word113 word114 word115 word116 word117 word118 word119 word120 word121 word122 word123 word124 word125 word126 word127 word128 word129 word130 word131 word132 word133 word134 word135 word136 word137 word138 word139 word140 word141 word142 word143 word144 word145 word146 word147 word148 word149 word150 word151 word152 word153 word154 word155 word156 word157 word158 word159 word160 word161 word162 word163 word164 word165 word166 word167 word168 word169 word170 word171 word172 word173 word174 word175 word176 word177 word178 word179 word180 word181 word182 word183 word184 word185 word186 word187 word188 word189 word190 word191 word192 word193 word194 word195 word196 word197 word198 word199 word200 word201 word202 word203 word204 word205 word206 word207 word208 word209 word210 word211 word212 word213 word214 word215 word216 word217 word218 word219 word220 word221 word222 word223 word224 word225 word226 word227 word228 word229 word230 word231 word232 word233 word234 word235 word236 word237 word238 word239 word240 word241 word242 word243 word244 word245 word246 word247 word248 word249 word250 word251 word252 word253 word254 word255 select0 selectb0 select1 selectb1 select2 selectb2 select3 selectb3 select4 selectb4 select5 selectb5 select6 selectb6 select7 selectb7 select8 selectb8 select9 selectb9 select10 selectb10 select11 selectb11 select12 selectb12 select13 selectb13 select14 selectb14 select15 selectb15 select16 selectb16 select17 selectb17 select18 selectb18 select19 selectb19 select20 selectb20 select21 selectb21 select22 selectb22 select23 selectb23 select24 selectb24 select25 selectb25 select26 selectb26 select27 selectb27 select28 selectb28 select29 selectb29 select30 selectb30 select31 selectb31 dram_bank_256x32
.model nmod nmos (level=1 vto=1 kp=100u lambda=0 is=0)
.model pmod pmos (level=1 vto=-1 kp=50u lambda=0 is=0)
.model psense pmos (level=1 vto=-1 kp=100u lambda=0 is=0)
.end
